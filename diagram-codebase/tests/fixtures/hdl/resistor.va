`include "disciplines.vams"
module resistor(p, n);
    inout p, n;
    electrical p, n;
    parameter real resistance = 1000.0;
    analog I(p, n) <+ V(p, n) / resistance;
endmodule
